* Boost converter, CCM: Ideal boost example (examples/synthetic/boost-ideal.yaml),
* the numbers of the in-browser simulator's preset "boost".
* Near-ideal parts: a 1 mOhm switch and diodes of about 30 mV (not from any design).
* Generated by scripts/sim_library.py; the same circuit as sim/ltspice/boost/boost-ccm.asc.
*
*   ngspice -b boost-ccm.cir         run it and print the measurements of the last period
*   ngspice boost-ccm.cir            then: run, and plot what the README lists

.param Vg=12 D=0.5 fs=100k L=100u C=10u R=20
.param Ts={1/fs}

V1 in 0 {Vg}                                       ; input voltage
Vgate gate 0 PULSE(0 1 0 10n 10n {D*Ts-10n} {Ts})  ; gate: 1 V for D*Ts every period
L1 in sw {L}                                       ; inductor
S1 sw 0 gate 0 SWITCH                              ; switch, on while the gate is high
D1 sw out DIODE                                    ; diode
C1 out 0 {C}                                       ; output capacitor
R1 out 0 {R}                                       ; load

.model SWITCH SW(Ron=1m Roff=1Meg Vt=0.5 Vh=0)
.model DIODE D(Is=1n N=0.05)

* 800 periods from rest; the last one is measured
.tran {Ts/200} {800*Ts} 0 {Ts/200} uic
.options method=gear reltol=1e-4
.meas tran v_sw_avg AVG v(sw) from={799*Ts} to={800*Ts}
.meas tran v_sw_max MAX v(sw) from={799*Ts} to={800*Ts}
.meas tran v_sw_min MIN v(sw) from={799*Ts} to={800*Ts}
.meas tran i_L_avg AVG i(l1) from={799*Ts} to={800*Ts}
.meas tran i_L_max MAX i(l1) from={799*Ts} to={800*Ts}
.meas tran i_L_min MIN i(l1) from={799*Ts} to={800*Ts}
.meas tran v_out_avg AVG v(out) from={799*Ts} to={800*Ts}
.meas tran v_out_max MAX v(out) from={799*Ts} to={800*Ts}
.meas tran v_out_min MIN v(out) from={799*Ts} to={800*Ts}
.end
