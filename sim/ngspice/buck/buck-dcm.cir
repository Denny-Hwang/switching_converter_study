* Buck converter, DCM: Buck example at light load (examples/synthetic/buck-light-load.yaml),
* the numbers of the in-browser simulator's preset "buck-light".
* Near-ideal parts: a 1 mOhm switch and diodes of about 30 mV (not from any design).
* Generated by scripts/sim_library.py; the same circuit as sim/ltspice/buck/buck-dcm.asc.
*
*   ngspice -b buck-dcm.cir         run it and print the measurements of the last period
*   ngspice buck-dcm.cir            then: run, and plot what the README lists

.param Vg=24 D=0.5 fs=100k L=100u C=10u R=100
.param Ts={1/fs}

V1 in 0 {Vg}                                       ; input voltage
Vgate gate 0 PULSE(0 1 0 10n 10n {D*Ts-10n} {Ts})  ; gate: 1 V for D*Ts every period
S1 in sw gate 0 SWITCH                             ; switch, on while the gate is high
D1 0 sw DIODE                                      ; diode, anode at ground
L1 sw out {L}                                      ; inductor
C1 out 0 {C}                                       ; output capacitor
R1 out 0 {R}                                       ; load

.model SWITCH SW(Ron=1m Roff=1Meg Vt=0.5 Vh=0)
.model DIODE D(Is=1n N=0.05)

* 1500 periods from rest; the last one is measured
.tran {Ts/200} {1500*Ts} 0 {Ts/200} uic
.options method=gear reltol=1e-4
.meas tran v_sw_avg AVG v(sw) from={1499*Ts} to={1500*Ts}
.meas tran v_sw_max MAX v(sw) from={1499*Ts} to={1500*Ts}
.meas tran v_sw_min MIN v(sw) from={1499*Ts} to={1500*Ts}
.meas tran i_L_avg AVG i(l1) from={1499*Ts} to={1500*Ts}
.meas tran i_L_max MAX i(l1) from={1499*Ts} to={1500*Ts}
.meas tran i_L_min MIN i(l1) from={1499*Ts} to={1500*Ts}
.meas tran v_out_avg AVG v(out) from={1499*Ts} to={1500*Ts}
.meas tran v_out_max MAX v(out) from={1499*Ts} to={1500*Ts}
.meas tran v_out_min MIN v(out) from={1499*Ts} to={1500*Ts}
.end
