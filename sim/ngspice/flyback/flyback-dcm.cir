* Flyback converter, DCM: Flyback example in DCM, ideal diode (examples/synthetic/flyback-dcm.yaml),
* the numbers of the in-browser simulator's preset "flyback-dcm".
* Near-ideal parts: a 1 mOhm switch and diodes of about 30 mV (not from any design).
* Generated by scripts/sim_library.py; the same circuit as sim/ltspice/flyback/flyback-dcm.asc.
*
*   ngspice -b flyback-dcm.cir         run it and print the measurements of the last period
*   ngspice flyback-dcm.cir            then: run, and plot what the README lists

.param Vg=48 D=0.3 fs=100k Lm=50u n=0.25 C=100u R=20
.param Ts={1/fs}

V1 in 0 {Vg}                                       ; input voltage
Vgate gate 0 PULSE(0 1 0 10n 10n {D*Ts-10n} {Ts})  ; gate: 1 V for D*Ts every period
Lp in d {Lm}                                       ; primary winding: the magnetizing inductance (dot at in)
Ls 0 sx {n*n*Lm}                                   ; secondary winding, n^2 Lm (dot at ground)
K1 Lp Ls 1                                         ; coupling 1: an ideal transformer beside Lm, n = sqrt(Ls/Lp)
S1 d 0 gate 0 SWITCH                               ; switch, on while the gate is high
D1 sx out DIODE                                    ; output diode
C1 out 0 {C}                                       ; output capacitor
R1 out 0 {R}                                       ; load

.model SWITCH SW(Ron=1m Roff=1Meg Vt=0.5 Vh=0)
.model DIODE D(Is=1n N=0.05)

* 2500 periods from rest; the last one is measured
.tran {Ts/200} {2500*Ts} 0 {Ts/200} uic
.options method=gear reltol=1e-4
.meas tran v_sw_avg AVG v(d) from={2499*Ts} to={2500*Ts}
.meas tran v_sw_max MAX v(d) from={2499*Ts} to={2500*Ts}
.meas tran v_sw_min MIN v(d) from={2499*Ts} to={2500*Ts}
.meas tran i_p_avg AVG i(lp) from={2499*Ts} to={2500*Ts}
.meas tran i_p_max MAX i(lp) from={2499*Ts} to={2500*Ts}
.meas tran i_p_min MIN i(lp) from={2499*Ts} to={2500*Ts}
.meas tran v_out_avg AVG v(out) from={2499*Ts} to={2500*Ts}
.meas tran v_out_max MAX v(out) from={2499*Ts} to={2500*Ts}
.meas tran v_out_min MIN v(out) from={2499*Ts} to={2500*Ts}
.end
