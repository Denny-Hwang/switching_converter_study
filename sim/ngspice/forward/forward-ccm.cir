* Forward converter with a reset winding, CCM: Forward converter example (examples/synthetic/forward-basic.yaml),
* the numbers of the in-browser simulator's preset "forward".
* Near-ideal parts: a 1 mOhm switch and diodes of about 30 mV (not from any design).
* Generated by scripts/sim_library.py; the same circuit as sim/ltspice/forward/forward-ccm.asc.
*
*   ngspice -b forward-ccm.cir         run it and print the measurements of the last period
*   ngspice forward-ccm.cir            then: run, and plot what the README lists

.param Vg=48 D=0.4 fs=100k L=100u Lm=1m n=0.5 nr=1 C=100u R=5
.param Ts={1/fs}

V1 in 0 {Vg}                                       ; input voltage
Vgate gate 0 PULSE(0 1 0 10n 10n {D*Ts-10n} {Ts})  ; gate: 1 V for D*Ts every period
Lp in d {Lm}                                       ; primary winding: the magnetizing inductance (dot at in)
Ls s1 0 {n*n*Lm}                                   ; secondary winding (dot at s1)
Lr 0 rn {nr*nr*Lm}                                 ; reset winding, nr^2 Lm (dot at ground)
K1 Lp Ls 1                                         ; the windings coupled pairwise with 1
K2 Lp Lr 1
K3 Ls Lr 1
S1 d 0 gate 0 SWITCH                               ; switch, on while the gate is high
Cd d 0 10p                                         ; drain capacitance, for the solver (see the README)
D3 rn in DIODE                                     ; reset diode: returns the magnetizing energy to the input
D1 s1 x DIODE                                      ; forward diode
D2 0 x DIODE                                       ; freewheeling diode
L1 x out {L}                                       ; output inductor
C1 out 0 {C}                                       ; output capacitor
R1 out 0 {R}                                       ; load

.model SWITCH SW(Ron=1m Roff=1Meg Vt=0.5 Vh=0)
.model DIODE D(Is=1n N=0.05)

* 1200 periods from rest; the last one is measured
.tran {Ts/200} {1200*Ts} 0 {Ts/200} uic
.options method=gear reltol=1e-4
.meas tran v_sw_avg AVG v(d) from={1199*Ts} to={1200*Ts}
.meas tran v_sw_max MAX v(d) from={1199*Ts} to={1200*Ts}
.meas tran v_sw_min MIN v(d) from={1199*Ts} to={1200*Ts}
.meas tran i_L_avg AVG i(l1) from={1199*Ts} to={1200*Ts}
.meas tran i_L_max MAX i(l1) from={1199*Ts} to={1200*Ts}
.meas tran i_L_min MIN i(l1) from={1199*Ts} to={1200*Ts}
.meas tran v_out_avg AVG v(out) from={1199*Ts} to={1200*Ts}
.meas tran v_out_max MAX v(out) from={1199*Ts} to={1200*Ts}
.meas tran v_out_min MIN v(out) from={1199*Ts} to={1200*Ts}
.end
